# Ansys Electronics Desktop project, version 2025.2
materials:
  vacuum: permittivity=1
  pec: conductivity=1e+30
  PMLGroup1_Z_1: permittivity{anisotropic component1=1.3875784 component2=1.3875784 component3=0.36034} permeability{anisotropic component1=1.3875784 component2=1.3875784 component3=0.36034} dielectric_loss_tangent{anisotropic component1=1 component2=1 component3=-1} magnetic_loss_tangent{anisotropic component1=1 component2=1 component3=-1}
  PMLGroup1_XZ_1: permittivity{anisotropic component1=1 component2=0.01 component3=1} permeability{anisotropic component1=1 component2=0.01 component3=1} dielectric_loss_tangent{anisotropic component1=0 component2=385.07477 component3=0} magnetic_loss_tangent{anisotropic component1=0 component2=385.07477 component3=0}
  PMLGroup1_YZ_1: permittivity{anisotropic component1=0.01 component2=1 component3=1} permeability{anisotropic component1=0.01 component2=1 component3=1} dielectric_loss_tangent{anisotropic component1=385.07477 component2=0 component3=0} magnetic_loss_tangent{anisotropic component1=385.07477 component2=0 component3=0}
  PMLGroup1_XYZ_1: permittivity{anisotropic component1=1.3875784 component2=1.3875784 component3=1.3875784} permeability{anisotropic component1=1.3875784 component2=1.3875784 component3=1.3875784} dielectric_loss_tangent{anisotropic component1=1 component2=1 component3=1} magnetic_loss_tangent{anisotropic component1=1 component2=1 component3=1}

design HFSSDesign1 (HFSS, HFSS Terminal Network, model units mm)
variables:
  dL = 0.056825
  dR = 0.5mm
  gL = 1m
geometry:
  dipole [pec] = cylinder(axis=Z, base_centre=(0mm, 0mm, 0-dL/2), radius=dR, height=dL)
  gap [vacuum] = cylinder(axis=Z, base_centre=(0mm, 0mm, 0-gL/2), radius=dR, height=gL)
  lumped_port_1 = gap.copy()
  dipole.subtract(lumped_port_1)
  lumped_port = gap.section(plane=YZ)
  RadiatingSurface [vacuum] = region(absolute_offset=31.25mm on all sides)
  coordinate_system FaceCS1 = face of RadiatingSurface: Origin=(31.75, -31.75, 59.6625) FaceID=RadiatingSurface.face(+z) AxisPosn=(31.75, 31.75, 59.6625) WhichAxis=X ZRotationAngle=0deg XOffset=0mm YOffset=0mm FaceNormal(0, 0, 1)
  PML_RadiatingSurface_1 [PMLGroup1_Z_1, oriented by FaceCS1] = sweep_along_normal(RadiatingSurface.face(+z), length=40.280883mm)
  coordinate_system FaceCS2 = face of RadiatingSurface: Origin=(31.75, -31.75, -59.6625) FaceID=RadiatingSurface.face(-z) AxisPosn=(-31.75, -31.75, -59.6625) WhichAxis=X ZRotationAngle=0deg XOffset=0mm YOffset=0mm FaceNormal(0, 0, -1)
  PML_RadiatingSurface_2 [PMLGroup1_Z_1, oriented by FaceCS2] = sweep_along_normal(RadiatingSurface.face(-z), length=40.280883mm)
  coordinate_system FaceCS3 = face of RadiatingSurface: Origin=(31.75, -31.75, 59.6625) FaceID=RadiatingSurface.face(-y) AxisPosn=(-31.75, -31.75, 59.6625) WhichAxis=X ZRotationAngle=0deg XOffset=0mm YOffset=0mm FaceNormal(0, -1, 0)
  PML_RadiatingSurface_3 [PMLGroup1_Z_1, oriented by FaceCS3] = sweep_along_normal(RadiatingSurface.face(-y), length=40.280883mm)
  coordinate_system FaceCS4 = face of RadiatingSurface: Origin=(-31.75, -31.75, 59.6625) FaceID=RadiatingSurface.face(-x) AxisPosn=(-31.75, 31.75, 59.6625) WhichAxis=X ZRotationAngle=0deg XOffset=0mm YOffset=0mm FaceNormal(-1, 0, 0)
  PML_RadiatingSurface_4 [PMLGroup1_Z_1, oriented by FaceCS4] = sweep_along_normal(RadiatingSurface.face(-x), length=40.280883mm)
  coordinate_system FaceCS5 = face of RadiatingSurface: Origin=(-31.75, 31.75, 59.6625) FaceID=RadiatingSurface.face(+y) AxisPosn=(31.75, 31.75, 59.6625) WhichAxis=X ZRotationAngle=0deg XOffset=0mm YOffset=0mm FaceNormal(0, 1, 0)
  PML_RadiatingSurface_5 [PMLGroup1_Z_1, oriented by FaceCS5] = sweep_along_normal(RadiatingSurface.face(+y), length=40.280883mm)
  coordinate_system FaceCS6 = face of RadiatingSurface: Origin=(31.75, 31.75, -59.6625) FaceID=RadiatingSurface.face(+x) AxisPosn=(31.75, 31.75, 59.6625) WhichAxis=X ZRotationAngle=0deg XOffset=0mm YOffset=0mm FaceNormal(1, 0, 0)
  PML_RadiatingSurface_6 [PMLGroup1_Z_1, oriented by FaceCS6] = sweep_along_normal(RadiatingSurface.face(+x), length=40.280883mm)
  PML_RadiatingSurface_7 [PMLGroup1_XZ_1, oriented by FaceCS1] = sweep_along_normal(PML_RadiatingSurface_1.face(at (0, -31.75, 79.8029)), length=40.280883mm)
  PML_RadiatingSurface_8 [PMLGroup1_YZ_1, oriented by FaceCS4] = sweep_along_normal(PML_RadiatingSurface_1.face(at (-31.75, 0, 79.8029)), length=40.280883mm)
  PML_RadiatingSurface_9 [PMLGroup1_YZ_1, oriented by FaceCS5] = sweep_along_normal(PML_RadiatingSurface_1.face(at (0, 31.75, 79.8029)), length=40.280883mm)
  PML_RadiatingSurface_10 [PMLGroup1_YZ_1, oriented by FaceCS1] = sweep_along_normal(PML_RadiatingSurface_1.face(at (31.75, 0, 79.8029)), length=40.280883mm)
  PML_RadiatingSurface_11 [PMLGroup1_YZ_1, oriented by FaceCS2] = sweep_along_normal(PML_RadiatingSurface_2.face(at (0, -31.75, -79.8029)), length=40.280883mm)
  coordinate_system FaceCS7 = face of RadiatingSurface: Origin=(-31.75, -31.75, -59.6625) FaceID=RadiatingSurface.face(-z) AxisPosn=(-31.75, 31.75, -59.6625) WhichAxis=X ZRotationAngle=0deg XOffset=0mm YOffset=0mm FaceNormal(0, 0, -1)
  PML_RadiatingSurface_12 [PMLGroup1_YZ_1, oriented by FaceCS7] = sweep_along_normal(PML_RadiatingSurface_2.face(at (-31.75, 0, -79.8029)), length=40.280883mm)
  coordinate_system FaceCS8 = face of RadiatingSurface: Origin=(-31.75, 31.75, -59.6625) FaceID=RadiatingSurface.face(-z) AxisPosn=(31.75, 31.75, -59.6625) WhichAxis=X ZRotationAngle=0deg XOffset=0mm YOffset=0mm FaceNormal(0, 0, -1)
  PML_RadiatingSurface_13 [PMLGroup1_YZ_1, oriented by FaceCS8] = sweep_along_normal(PML_RadiatingSurface_2.face(at (0, 31.75, -79.8029)), length=40.280883mm)
  PML_RadiatingSurface_14 [PMLGroup1_XZ_1, oriented by FaceCS2] = sweep_along_normal(PML_RadiatingSurface_2.face(at (31.75, 0, -79.8029)), length=40.280883mm)
  PML_RadiatingSurface_15 [PMLGroup1_XZ_1, oriented by FaceCS4] = sweep_along_normal(PML_RadiatingSurface_3.face(at (-31.75, -51.8904, 0)), length=40.280883mm)
  PML_RadiatingSurface_16 [PMLGroup1_XZ_1, oriented by FaceCS3] = sweep_along_normal(PML_RadiatingSurface_3.face(at (31.75, -51.8904, 0)), length=40.280883mm)
  PML_RadiatingSurface_17 [PMLGroup1_XZ_1, oriented by FaceCS5] = sweep_along_normal(PML_RadiatingSurface_4.face(at (-51.8904, 31.75, 0)), length=40.280883mm)
  PML_RadiatingSurface_18 [PMLGroup1_YZ_1, oriented by FaceCS6] = sweep_along_normal(PML_RadiatingSurface_5.face(at (31.75, 51.8904, 0)), length=40.280883mm)
  PML_RadiatingSurface_19 [PMLGroup1_XYZ_1, oriented by FaceCS4] = sweep_along_normal(PML_RadiatingSurface_7.face(at (-31.75, -51.8904, 79.8029)), length=40.280883mm)
  PML_RadiatingSurface_20 [PMLGroup1_XYZ_1, oriented by FaceCS1] = sweep_along_normal(PML_RadiatingSurface_7.face(at (31.75, -51.8904, 79.8029)), length=40.280883mm)
  PML_RadiatingSurface_21 [PMLGroup1_XYZ_1, oriented by FaceCS5] = sweep_along_normal(PML_RadiatingSurface_8.face(at (-51.8904, 31.75, 79.8029)), length=40.280883mm)
  coordinate_system FaceCS9 = face of RadiatingSurface: Origin=(31.75, 31.75, 59.6625) FaceID=RadiatingSurface.face(+z) AxisPosn=(-31.75, 31.75, 59.6625) WhichAxis=X ZRotationAngle=0deg XOffset=0mm YOffset=0mm FaceNormal(0, 0, 1)
  PML_RadiatingSurface_22 [PMLGroup1_XYZ_1, oriented by FaceCS9] = sweep_along_normal(PML_RadiatingSurface_9.face(at (31.75, 51.8904, 79.8029)), length=40.280883mm)
  PML_RadiatingSurface_23 [PMLGroup1_XYZ_1, oriented by FaceCS7] = sweep_along_normal(PML_RadiatingSurface_11.face(at (-31.75, -51.8904, -79.8029)), length=40.280883mm)
  PML_RadiatingSurface_24 [PMLGroup1_XYZ_1, oriented by FaceCS2] = sweep_along_normal(PML_RadiatingSurface_11.face(at (31.75, -51.8904, -79.8029)), length=40.280883mm)
  PML_RadiatingSurface_25 [PMLGroup1_XYZ_1, oriented by FaceCS8] = sweep_along_normal(PML_RadiatingSurface_12.face(at (-51.8904, 31.75, -79.8029)), length=40.280883mm)
  PML_RadiatingSurface_26 [PMLGroup1_XYZ_1, oriented by FaceCS6] = sweep_along_normal(PML_RadiatingSurface_13.face(at (31.75, 51.8904, -79.8029)), length=40.280883mm)
  group PMLGroup1 = PML_RadiatingSurface_1..PML_RadiatingSurface_26
boundaries and excitations:
  PML_radiation1: Radiation Faces=RadiatingSurface.face(+z) IsForPML
  PML_radiation2: Radiation Faces=RadiatingSurface.face(-z) IsForPML
  PML_radiation3: Radiation Faces=RadiatingSurface.face(-y) IsForPML
  PML_radiation4: Radiation Faces=RadiatingSurface.face(-x) IsForPML
  PML_radiation5: Radiation Faces=RadiatingSurface.face(+y) IsForPML
  PML_radiation6: Radiation Faces=RadiatingSurface.face(+x) IsForPML
  1: Lumped Port Objects=lumped_port LumpedPortType=Modal Modes{Mode1{IntLine{(0, 0, 0.5) -> (0, 0, -0.5)} CharImp=Zpi RenormImp=50ohm}} Impedance=50ohm
setups:
  2_4GHz: HfssDriven Frequency=2.4GHz MaxDeltaS=0.02 MaximumPasses=99 MinimumPasses=1 MinimumConvergedPasses=1 PercentRefinement=30 BasisOrder=1 PortAccuracy=2 DrivenSolverType="Direct Solver"
    sweep 1800_3000MHz: 1.8GHz to 3GHz, 401 points; Type=Interpolating InterpTolerance=0.5 InterpMaxSolns=250 PassivityErrorTolerance=0.0001
source amplitudes:
  1:1: 1V 0deg
optimetrics:
  dipole_length: Parametric Sim._Setups=[2_4GHz]
    sweep dL: LINC 0.0567 0.0572 5
radiation setups:
  3D: Infinite Sphere Theta=0deg..180deg step 2deg Phi=-180deg..180deg step 2deg
  Elevation: Infinite Sphere Theta=-180deg..180deg step 1deg Phi=0deg..90deg step 90deg
  Azimuth: Infinite Sphere Theta=90deg..90deg step 0deg Phi=-180deg..180deg step 1deg
  3D_sphere: Infinite Sphere Theta=0deg..180deg step 1deg Phi=-180deg..180deg step 1deg
  p_plane: Infinite Sphere Theta=-180deg..180deg step 1deg Phi=0deg..0deg step 0deg
reports:
  S Parameter Plot1: dB(S(1,1)) vs Freq on 2_4GHz : 1800_3000MHz [dL=0.0567,0.056825,0.05695,0.057075,0.0572,0.0625]; markers m1 at 2.184GHz
  Z Parameter Plot1: re(Z(1,1)), im(Z(1,1)) vs Freq on 2_4GHz : 1800_3000MHz [dL=0.056825]; markers m1 at 2.4GHz, m2 at 2.313GHz, m3 at 2.31GHz, m4 at 2.313GHz, m5 at 2.313GHz, m6 at 2.4GHz, m7 at 2.428215GHz, m8 at 2.4GHz, m9 at 2.428215GHz
  Cut Plane Plot: dB(GainTotal) vs Theta on 2_4GHz : LastAdaptive, p_plane [Phi=all Freq=2.4GHz]
  Directivity Plot1: dB(DirTotal) vs Phi, Theta on 2_4GHz : LastAdaptive, 3D [Freq=2.4GHz]
  Terminal S Parameter Chart1: St(1,1) on 2_4GHz : 1800_3000MHz [Freq=all]; markers m1 at 2.211GHz, m2 at 2.4GHz, m3 at 2.43GHz
